* Powered 5 V to 2.5 V divider
V1 VIN 0 DC 5
R1 VIN VOUT 10k
R2 VOUT 0 10k
.tran 10u 10m
.end
